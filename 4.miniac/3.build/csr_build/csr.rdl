addrmap csr {
   name = "csr";
   desc = "uberClock CSR";

   littleendian;
   default accesswidth = 32;
   default regwidth = 32;
   default alignment = 4;
   addressing = compact;

   regfile uart {
      name = "csr.uart";
      desc = "UART CSR";

      reg {
         name = "csr.uart.rx";
         desc = "UART Rx Register";
         
         field {
            name = "csr.uart.rx.valid";
            desc = "Indicates valid data transfer from the UART to the CPU";
            sw = r;
            hw = w;
         } valid[31:31] = 0;
         
         field {
            name = "csr.uart.rx.oflow";
            desc = "Indicates that some data bytes are lost";
            sw = r;
            hw = w;
         } oflow[30:30] = 0;
         
         field {
            name = "csr.uart.rx.data[7:0]";
            desc = "Received data";
            sw = r;
            hw = w;
            swacc = true;
         } data[7:0] = 0;
      } rx;

      reg {
         name = "csr.uart.rx_trigger";
         desc = "UART Rx Trigger Register";
         
         field {
            name = "csr.uart.rx_trigger.read";
            desc = "Indicates that the CPU can accept next data transfer, used internally - don't try to read or write!";
         } read = 0;
      } rx_trigger;

      rx_trigger.read->next = rx.data->swacc;

      reg {
         name = "csr.uart.tx";
         desc = "UART Tx Register";

         field {
            name = "csr.uart.tx.busy";
            desc = "Indicates that UART cannot accept next data transfer";
            sw = r;
            hw = w;
         } busy[31:31] = 0;

         field {
            name = "csr.uart.tx.data[7:0]";
            desc = "Data to send";
            sw = rw;
            hw = r;
            swmod = true;
         } data[7:0] = 0;
      } tx;

      reg {
         name = "csr.uart.tx_trigger";
         desc = "UART Tx Trigger Register";

         field {
            name = "csr.uart.tx_trigger.write";
            desc = "Indicates valid data transfer from the CPU to the UART, used internally - don't try to read or write!";
         } write = 0;
      } tx_trigger;

      tx_trigger.write->next = tx.data->swmod;
   } uart;

   reg {
      name = "csr.gpio";
      desc = "GPIO Register";

      field {
         name = "csr.gpio.led2";
         desc = "Output to LED2 (0 - off, 1 - on)";
         sw = rw;
         hw = r;
      } led2[9:9] = 0;

      field {
         name = "csr.gpio.led1";
         desc = "Output to LED1 (0 - off, 1 - on)";
         sw = rw;
         hw = r;
      } led1[8:8] = 0;

      field {
         name = "csr.gpio.key2";
         desc = "Input from KEY2 (0 - not pressed, 1 - pressed)";
         sw = r;
         hw = w;
      } key2[1:1] = 0;

      field {
         name = "csr.gpio.key1";
         desc = "Input from KEY1 (0 - not pressed, 1 - pressed)";
         sw = r;
         hw = w;
      } key1[0:0] = 0;
   } gpio;

   reg {
      name = "csr.hw_id";
      desc = "Hardware IDs";

      field {
         name = "csr.hw_id.VENDOR";
         desc = "Vendor ID";
         sw = r;
         hw = r;
      } VENDOR[31:16] = 0xCCAE;

      field {
         name = "csr.hw_id.PRODUCT";
         desc = "Product ID";
         sw = r;
         hw = r;
      } PRODUCT[15:0] = 0xC10C;
   } hw_id;
   
   
   
   reg {
      name = "csr.adc";
      desc = "ADC Register";

      // START flag: CPU piše (W), ADC Kontroler čita (R). CPU će napisati 1 kao puls.
      field {
         name = "csr.adc.start";
         desc = "Control: Start ADC data transfer to DMEM (SW writes 1, HW reads)";
         sw = w;	// Software Write Only
         hw = r;	// Hardware Read Only
      } start[31:31] = 0;

      // DONE flag: ADC Kontroler piše (W), CPU čita (R). HW setuje 1 kada završi.
      field {
         name = "csr.adc.done";
         desc = "Status: ADC data transfer finished (HW writes 1, SW reads)";
         sw = r;	// Software Read Only
         hw = w;	// Hardware Write Only
      } done[30:30] = 0;

      field {
         name = "csr.adc.ch1";
         desc = "Implement the first channel for the AD converter";
         sw = r;
         hw = w;
      } ch1[27:16] = 0;

      field {
         name = "csr.adc.ch2";
         desc = "Implement the second channel for the AD converter";
         sw = r;
         hw = w;
      } ch2[11:0] = 0;
   } adc;
   
   reg {
      name = "csr.dac";
      desc = "DAC Register";

      field {
         name = "csr.dac.ch1";
         desc = "Implement the first channel for the DA converter";
         sw = rw;
         hw = r;
      } ch1[29:16] = 0;

      field {
         name = "csr.dac.ch2";
         desc = "Implement the second channel for the DA converter";
         sw = rw;
         hw = r;
      } ch2[13:0] = 0;
   } dac;

   reg {
      name = "csr.hw_version";
      desc = "Hardware Version";

      field {
         name = "csr.hw_version.MAJOR";
         desc = "Major version";
         sw = r;
         hw = r;
      } MAJOR[31:24] = 0x00;

      field {
         name = "csr.hw_version.MINOR";
         desc = "Minor version";
         sw = r;
         hw = r;
      } MINOR[23:16] = 0x01;

      field {
         name = "csr.hw_version.PATCH";
         desc = "Patch version";
         sw = r;
         hw = r;
      } PATCH[15:0] = 0x0000;
   } hw_version;
   
   external mem dac_mem {
      name = "dac_mem";
      desc = "DAC Memory";
      mementries = 2048;
      memwidth = 32;
   } dac_mem @ 0x2000;
};

addrmap uberclock {
   littleendian;
   default accesswidth = 32;
   default regwidth = 32;
   default alignment = 4;
   addressing = compact;

   external mem imem {
      name = "imem";
      desc = "CPU Program Memory";
      mementries = 8192;
      memwidth = 32;
   } imem @ 0x0000_0000;

   external mem dmem {
      name = "dmem";
      desc = "CPU Data Memory";
      mementries = 8192;
      memwidth = 32;
   } dmem @ 0x1000_0000;

   csr csr @ 0x2000_0000;
};
